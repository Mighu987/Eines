# Ansys Electronics Desktop project, version 2024.2
materials:
  vacuum: permittivity=1
  copper: permeability=0.999991 conductivity=58000000

design Maxwell2DDesign1 (Maxwell 2D, Electrostatic, XY geometry, model units mm)
geometry:
  Rectangle1 [vacuum] = rectangle(corner=(-40mm, -100mm, 0mm), x_size=80mm, y_size=200mm)
  Polyline1 [non-model] = polyline((-40mm, 0mm, 0mm) (40mm, 0mm, 0mm))
boundaries and excitations:
  Symmetry1: Symmetry Edges=Rectangle1.edge(at (0, 100, 0)) IsOdd=false
  Symmetry2: Symmetry Edges=Rectangle1.edge(at (0, -100, 0)) IsOdd=false
  Voltage1: Voltage Edges=Rectangle1.edge(at (40, 0, 0)) Value=0mV
  Voltage2: Voltage Edges=Rectangle1.edge(at (-40, 0, 0)) Value=1V
  ChargeDensity1: Charge Density Objects=Rectangle1 Value=-1e-08
setups:
  Setup1: Electrostatic MaximumPasses=10 MinimumPasses=2 MinimumConvergedPasses=1 PercentRefinement=30 PercentError=1 ConstantDelta=0s NonLinearResidual=0.001
  Setup2: Electrostatic MaximumPasses=10 MinimumPasses=2 MinimumConvergedPasses=1 PercentRefinement=30 PercentError=1 ConstantDelta=0s NonLinearResidual=0.001
field plots:
  Voltage1: Voltage over Rectangle1 on Setup1 : LastAdaptive
reports:
  Calculator Expressions Plot 1: Voltage vs Distance on Setup2 : LastAdaptive
  Calculator Expressions Plot 2: Mag_E vs Distance on Setup2 : LastAdaptive
