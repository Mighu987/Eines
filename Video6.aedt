# Ansys Electronics Desktop project, version 2024.2
materials:
  vacuum: permittivity=1
  Teflon_custom: permittivity=2.08 dielectric_loss_tangent=0.0004

design HFSSDesign1 (HFSS, HFSS Modal Network, model units mm)
variables:
  a = 5mm
  length = 30mm
geometry:
  wg_fil [Teflon_custom] = cylinder(axis=Z, base_centre=(0mm, 0mm, 0mm), radius=a, height=length)
boundaries and excitations:
  1: Wave Port Faces=wg_fil.face(-z end) WavePortType=Default NumModes=5 Modes{Mode1{CharImp=Zpi} Mode2{CharImp=Zpi} Mode3{CharImp=Zpi} Mode4{CharImp=Zpi} Mode5{CharImp=Zpi}}
  2: Wave Port Faces=wg_fil.face(+z end) WavePortType=Default NumModes=5 Modes{Mode1{CharImp=Zpi} Mode2{CharImp=Zpi} Mode3{CharImp=Zpi} Mode4{CharImp=Zpi} Mode5{CharImp=Zpi}}
setups:
  Setup1: HfssDriven Frequency=17GHz MaxDeltaS=0.02 MaximumPasses=6 MinimumPasses=1 MinimumConvergedPasses=1 PercentRefinement=30 BasisOrder=1 PortAccuracy=2 DrivenSolverType="Direct Solver"
    sweep Sweep: 10GHz to 25GHz, 401 points; Type=Interpolating SaveFields InterpTolerance=0.5 InterpMaxSolns=250 InterpUsePortImped=false PassivityErrorTolerance=0.0001
source amplitudes:
  1:1: 1W 0deg
  1:2..1:5, 2:1..2:5: 0W 0deg
field plots:
  Mag_E1: E Field over wg_fil on Setup1 : Sweep at Freq=25GHz Phase=0deg
reports:
  Gamma Plot 1: im(Gamma(1:1)), im(Gamma(1:2)), im(Gamma(1:3)), im(Gamma(1:4)), im(Gamma(1:5)) vs Freq on Setup1 : Sweep
